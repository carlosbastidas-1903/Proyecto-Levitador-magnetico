* ============================================================
* MAGLEV - FORMA CANONICA OBSERVABLE (corregida, valores escalados) - version con el ADTL084 REAL de LTspice
* x1' = 196200 y - 280.14 u ; x2' = x1 + 1962 y ; x3' = x2 - 100 y ; y = x3
* Integradores Deboo U17,U18,U19 : R=45.15k, C=1u  (w0 = sqrt(1962) rad/s)
* Cadena: U16(sumador)->U20(inv)->U17 ; U21(sumador)->U18 ; U27(sumador)->U19
* Y_est = salida de U19, entra DIRECTO a U16, U21 y U27
* ============================================================

V7 VCC 0 10
V8 0 VEE 10
V10 U 0 PULSE(0 0.5 0 1u 1u 10 20)
* --- etapa 1
XU16 0 N2 VCC VEE A16 ADTL084
R83 A16 N2 10k
R88 Y_est N2 4.429k
XU20 0 N19 VCC VEE A20 ADTL084
R74 A16 N19 10k
R73 A20 N19 10k
R84 U N19 3.102Meg
R64 A20 N6 45.15k
R62 X1 N6 45.15k
C9 N6 0 1u
R61 N7 0 100k
R63 X1 N7 100k
XU17 N6 N7 VCC VEE X1 ADTL084
* --- etapa 2
XU21 0 N20 VCC VEE A21 ADTL084
R75 X1 N20 10k
R76 A21 N20 10k
R79 Y_est N20 10k
R68 A21 N10 45.15k
R66 X2 N10 45.15k
C10 N10 0 1u
R65 N11 0 100k
R67 X2 N11 100k
XU18 N10 N11 VCC VEE X2 ADTL084
* --- etapa 3
XU27 0 M27 VCC VEE A27 ADTL084
R78 X2 M27 10k
R77 A27 M27 10k
R80 Y_est M27 4.429k
R72 A27 N14 45.15k
R70 Y_est N14 45.15k
C11 N14 0 1u
R69 N15 0 100k
R71 Y_est N15 100k
XU19 N14 N15 VCC VEE Y_est ADTL084
.lib ADTL084.lib
.tran 0 0.2 0 100u
;  Si algo no arranca, prueba en su lugar:   .tran 0 0.2 0 100u uic
.end
